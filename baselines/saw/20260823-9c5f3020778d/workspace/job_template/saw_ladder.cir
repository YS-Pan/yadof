Ninth-order 1 GHz SAW ladder filter, BVD resonators, 50 ohm terminations
* Topology: five series resonators and four shunt resonators.
* User variables are fs and C0. K2=9% and Q=1000 are fixed task physics.
*
* Coupling convention:
*   K2 = (pi/2)*(fs/fp)*cot((pi/2)*(fs/fp))
* At K2=0.09: fp/fs=1.039356771357698 and Cm/C0=0.0802624981670983.
* BVD conversion:
*   Cm=C0*cmratio; Lm=1/((2*pi*fs)^2*Cm); Rm=2*pi*fs*Lm/Q.

.param fs_s_outer=991.435544312Meg fs_s_inner=1003.525113025Meg fs_s_center=1005.593049913Meg
.param fs_p_outer=954.358001651Meg fs_p_inner=969.883588501Meg
.param c0_s_outer=3.581575551p c0_s_inner=1.093852739p c0_s_center=1.018628471p
.param c0_p_outer=5.224977394p c0_p_inner=2.692304596p
.param k2=0.09 fpfs=1.039356771357698 cmratio=0.0802624981670983 qres=1000

.subckt saw_bvd p n params: fs=1G cstat=1p
.param cm={cstat*cmratio}
.param lm={1/(39.47841760435743*fs*fs*cm)}
.param rm={6.283185307179586*fs*lm/qres}
Cstat p n {cstat}
Rmot p mot1 {rm}
Lmot mot1 mot2 {lm}
Cmot mot2 n {cm}
.ends saw_bvd

Vdrive src 0 AC 1
Rsource src in 50

Xs1 in n1 saw_bvd FS={fs_s_outer} CSTAT={c0_s_outer}
Xp1 n1 0 saw_bvd FS={fs_p_outer} CSTAT={c0_p_outer}
Xs2 n1 n2 saw_bvd FS={fs_s_inner} CSTAT={c0_s_inner}
Xp2 n2 0 saw_bvd FS={fs_p_inner} CSTAT={c0_p_inner}
Xs3 n2 n3 saw_bvd FS={fs_s_center} CSTAT={c0_s_center}
Xp3 n3 0 saw_bvd FS={fs_p_inner} CSTAT={c0_p_inner}
Xs4 n3 n4 saw_bvd FS={fs_s_inner} CSTAT={c0_s_inner}
Xp4 n4 0 saw_bvd FS={fs_p_outer} CSTAT={c0_p_outer}
Xs5 n4 out saw_bvd FS={fs_s_outer} CSTAT={c0_s_outer}

Rload out 0 50

* With a 1 V Thevenin source and matched Z0 terminations:
* S21=2*Vout/Vdrive and S11=2*Vin/Vdrive-1.
B_s21 s21 0 V=2*v(out)
B_s11 s11 0 V=2*v(in)-v(src)

.ac lin 1201 850Meg 1150Meg
.end
