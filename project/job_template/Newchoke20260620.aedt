# Ansys Electronics Desktop project, version 2024.2
materials:
  vacuum: permittivity=1
  aluminum: permeability=1.000021 conductivity=38000000
  PVC plastic: permittivity=2.7 dielectric_loss_tangent=0.007
  air: permittivity=1.0006 permeability=1.0000004

design HFSSDesign1 (HFSS, HFSS Modal Network, model units mm)
options: Allow_Material_Override
variables:
  D1 = 14.3408mm  # optimise 1mm..3mm
  L1 = 10.582mm  # optimise 4mm..12mm
  Al1 = 5.32146mm  # optimise 2mm..6mm
  Ah1 = 9.43221mm  # optimise 2mm..6mm
  D2 = 2.91845mm  # optimise 2mm..6mm
  L2 = 1.70019mm  # optimise 4mm..12mm
  Al2 = 2.50788mm  # optimise 2mm..6mm
  Ah2 = 1.83968mm  # optimise 2.5mm..7.5mm
  D3 = 0.225731mm  # optimise 2mm..6mm
  L3 = 5.4836mm  # optimise 4mm..12mm
  Al3 = 0.448458mm  # optimise 2mm..6mm
  Ah3 = 8.50485mm  # optimise 2.5mm..7.5mm
  D4 = 2.04508mm  # optimise 2mm..6mm
  L4 = 7.6636mm  # optimise 4mm..12mm
  Al4 = 5.15434mm  # optimise 2.5mm..7.5mm
  Ah4 = 9.16234mm  # optimise 2mm..6mm
  D5 = 7.41787mm  # optimise 2mm..6mm
  L5 = 3.13419mm  # optimise 4mm..12mm
  Al5 = 1.77191mm  # optimise 2.5mm..7.5mm
  Ah5 = 1.52638mm  # optimise 2mm..6mm
  N = 5  # optimise 2..6
  Bore2Radius = plasticOuter  # Inner Radius of metal part
  plasticOuter = 5.6mm  # optimise 2.8mm..8.4mm
  plasticInner = 4.6mm  # optimise 2.3mm..6.9mm
  plasticLen = 80mm
  trump0Len = 13.8458mm  # optimise 4mm..12mm
  trump0Width = 5.88538mm  # optimise 5mm..15mm
  trumpH = 35.49mm  # optimise 20mm..60mm
  Angle = -45.6798  # degree; optimise -45..-15
  trump1Len = 26mm  # optimise 13mm..39mm
  trump1Width = 25mm  # optimise 12.5mm..37.5mm
  rearPlasticLen = 15.4186mm  # optimise 7.5mm..22.5mm
  cornerLen = 21.5587mm  # Y-Axis length; optimise 8mm..24mm
  cornerWidth = 19.8707mm  # Z-Axis length; optimise 10mm..30mm
  cornerPOSy = -0.5*cornerLen
  cornerPOSz = -0.5*cornerWidth
  cornerPOSy1 = -0.5*cornerLen1
  cornerPOSz1 = -0.5*cornerWidth1
  cornerLen1 = 25.5383mm  # Y-Axis length; optimise 4mm..12mm
  cornerWidth1 = 20.2484mm  # Z-Axis length; optimise 5mm..15mm
  cornerH = 3.13904mm  # optimise 7mm..21mm
  chokeInnerRadius = plasticOuter+0.1mm  # DO NOT CHANGE - min radius of choke part
  chokeZshift = 3.83071mm  # optimise 7.5mm..22.5mm
  d01 = 1.2mm
  FrontOuterRadius = 16mm
  RearOuterRadius = 16mm
geometry:
  Choke [air] = equation_curve(x=if(_t<D1,0,if(_t<D1+L1,Al1+(Ah1-Al1)*(_t-D1)/L1,0))+if(_t<2*D1+L1+D2,0,if(_t<2*D1+L1+D2+L2,Al2+(Ah2-Al2)*(_t-(2*D1+L1+D2))/L2,0))+if(_t<2*D1+L1+2*D2+L2+D3,0,if(_t<2*D1+L1+2*D2+L2+D3+L3,Al3+(Ah3-Al3)*(_t-(2*D1+L1+2*D2+L2+D3))/L3,0))+if(_t<2*D1+L1+2*D2+L2+2*D3+L3+D4,0,if(_t<2*D1+L1+2*D2+L2+2*D3+L3+D4+L4,Al4+(Ah4-Al4)*(_t-(2*D1+L1+2*D2+L2+2*D3+L3+D4))/L4,0))+if(_t<2*D1+L1+2*D2+L2+2*D3+L3+2*D4+L4+D5,0,if(_t<2*D1+L1+2*D2+L2+2*D3+L3+2*D4+L4+D5+L5,Al5+(Ah5-Al5)*(_t-(2*D1+L1+2*D2+L2+2*D3+L3+2*D4+L4+D5))/L5,0)), y=0, z=_t, _t=0 to if(N<1.5,2*D1+L1,if(N<2.5,2*D1+L1+2*D2+L2,if(N<3.5,2*D1+L1+2*D2+L2+2*D3+L3,if(N<4.5,2*D1+L1+2*D2+L2+2*D3+L3+2*D4+L4,2*D1+L1+2*D2+L2+2*D3+L3+2*D4+L4+2*D5+L5)))), segments=2000)
  Polyline1 = polyline((0mm, 0mm, 0mm) (0mm, 0mm, if(N<1.5,2*D1+L1,if(N<2.5,2*D1+L1+2*D2+L2,if(N<3.5,2*D1+L1+2*D2+L2+2*D3+L3,if(N<4.5,2*D1+L1+2*D2+L2+2*D3+L3+2*D4+L4,2*D1+L1+2*D2+L2+2*D3+L3+2*D4+L4+2*D5+L5))))))
  Polyline2 = polyline((chokeInnerRadius, 0mm, 0mm) (0mm, 0mm, 0mm))
  Polyline3 = polyline((0mm, 0mm, if(N<1.5,2*D1+L1,if(N<2.5,2*D1+L1+2*D2+L2,if(N<3.5,2*D1+L1+2*D2+L2+2*D3+L3,if(N<4.5,2*D1+L1+2*D2+L2+2*D3+L3+2*D4+L4,2*D1+L1+2*D2+L2+2*D3+L3+2*D4+L4+2*D5+L5))))) (chokeInnerRadius, 0mm, if(N<1.5,2*D1+L1,if(N<2.5,2*D1+L1+2*D2+L2,if(N<3.5,2*D1+L1+2*D2+L2+2*D3+L3,if(N<4.5,2*D1+L1+2*D2+L2+2*D3+L3+2*D4+L4,2*D1+L1+2*D2+L2+2*D3+L3+2*D4+L4+2*D5+L5))))))
  bore = cylinder(axis=Z, base_centre=(0mm, 0mm, -40mm), radius=chokeInnerRadius, height=120mm)
  frontInner = cylinder(axis=Z, base_centre=(0mm, 0mm, 0mm), radius=plasticInner, height=plasticLen)
  RearInner = cylinder(axis=Z, base_centre=(0mm, 0mm, 0mm), radius=plasticInner, height=-rearPlasticLen)
  coordinate_system RelativeCS1 = origin=(0mm, 0mm, -5mm) x=(cos(Angle/180*pi), 0, -sin(Angle/180*pi)) y=(0mm, 1mm, 0mm)
  trump0 = rectangle(corner=(0mm, -0.5*trump0Len, -0.5*trump0Width), y_size=trump0Len, z_size=trump0Width) in RelativeCS1
  trump1 = rectangle(corner=(trumpH, -0.5*trump1Len, -0.5*trump1Width), y_size=trump1Len, z_size=trump1Width) in RelativeCS1
  trump0.connect(trump1)
  port4 [aluminum] = cylinder(axis=Z, base_centre=(0mm, 0mm, 80mm), radius=Bore2Radius, height=1mm)
  port3 [aluminum] = cylinder(axis=Z, base_centre=(0mm, 0mm, -41mm), radius=Bore2Radius, height=1mm)
  corner0 = rectangle(corner=(0mm, cornerPOSy, cornerPOSz), y_size=cornerLen, z_size=cornerWidth)
  corner1 = rectangle(corner=(-cornerH, cornerPOSy1, cornerPOSz1), y_size=cornerLen1, z_size=cornerWidth1)
  corner0.connect(corner1)
  port1port2 [aluminum] = box(corner=(trumpH, -0.5*(1mm+trump1Len), -0.5*(1mm+trump1Width)), size=(1mm, trump1Len+1mm, trump1Width+1mm)) in RelativeCS1
  port1 = rectangle(corner=(trumpH, 2mm, -10mm), y_size=8mm, z_size=20mm) in RelativeCS1
  port2 = rectangle(corner=(trumpH, -10mm, -10mm), y_size=8mm, z_size=20mm) in RelativeCS1
  RearPlastic = cylinder(axis=Z, base_centre=(0mm, 0mm, 0mm), radius=plasticOuter, height=-rearPlasticLen)
  frontPlastic [PVC plastic] = cylinder(axis=Z, base_centre=(0mm, 0mm, 0mm), radius=plasticOuter, height=plasticLen)
  frontInner.unite(RearInner)
  frontPlastic.unite(RearPlastic)
  frontPlastic.subtract(frontInner)
  Box1 [PVC plastic, non-model] = box(corner=(5mm, -0.5mm, 80.5mm), size=(1mm, 1mm, -1mm))
  Box2 [PVC plastic, non-model] = box(corner=(4mm, -0.5mm, -39.5mm), size=(1mm, 1mm, -1mm))
  Choke.move(chokeInnerRadius, 0mm, 0mm)
  Choke.unite(Polyline1, Polyline2, Polyline3)
  Choke.cover_lines()
  Choke.move(0mm, 0mm, chokeZshift)
  Choke.sweep_around_axis(axis=Z, angle=360deg)
  RearMetalShell [aluminum] = cylinder(axis=Z, base_centre=(0mm, 0mm, -40mm), radius=plasticOuter+0.1mm, height=120mm-plasticLen-rearPlasticLen)
  RearMetalInner = cylinder(axis=Z, base_centre=(0mm, 0mm, -40mm), radius=plasticInner, height=120mm-plasticLen-rearPlasticLen)
  RearMetalShell.subtract(RearMetalInner)
  Choke.unite(bore, corner0, trump0)
  coordinate_system RelativeCS2 = origin=(0mm, 0mm, 0mm) x=(1mm, 0mm, 0mm) y=(0mm, 0mm, 1mm)
boundaries and excitations:
  1: Wave Port Objects=port1 WavePortType=Modal NumModes=3 Modes{Mode1{IntLine{(31.950176, 6, 13.404519) -> (17.641247, 6, 27.37787)} CharImp=Zpi} Mode2{IntLine{(24.795712, 2, 20.391195) -> (24.795712, 10, 20.391195)} CharImp=Zpi} Mode3{CharImp=Zpi}} UseAnalyticAlignment AnalyticULine{(31.950176, 6, 13.404519) -> (17.641247, 6, 27.37787)} AnalyticReverseV
  2: Wave Port Objects=port2 WavePortType=Modal NumModes=3 Modes{Mode1{IntLine{(31.950176, -6, 13.404519) -> (17.641247, -6, 27.37787)} CharImp=Zpi} Mode2{IntLine{(24.795712, -10, 20.391195) -> (24.795712, -2, 20.391195)} CharImp=Zpi} Mode3{CharImp=Zpi}} UseAnalyticAlignment AnalyticULine{(31.950176, -6, 13.404519) -> (17.641247, -6, 27.37787)} AnalyticReverseV
  3: Wave Port Faces=port3.face(+z end) WavePortType=Modal NumModes=2 UseLineModeAlignment Modes{Mode1{IntLine{(-5.6, 0, -40) -> (5.6, 0, -40)} CharImp=Zpi} Mode2{IntLine{(0, 5.6, -40) -> (0, -5.6, -40)} CharImp=Zpi}}
  4: Wave Port Faces=port4.face(-z end) WavePortType=Modal NumModes=2 UseLineModeAlignment Modes{Mode1{IntLine{(-5.6, 0, 80) -> (5.6, 0, 80)} CharImp=Zpi} Mode2{IntLine{(0, 5.6, 80) -> (0, -5.6, 80)} CharImp=Zpi}}
setups:
  Auto1: HfssDriven Frequency=24.3GHz MaxDeltaS=0.02 MaximumPasses=6 MinimumPasses=1 MinimumConvergedPasses=1 PercentRefinement=30 BasisOrder=-1 PortAccuracy=2 DrivenSolverType="Iterative Solver" IterativeResidual=0.0001 DDMSolverResidual=0.0001 SaveAnyFields=false
    sweep Sweep: 23.5GHz to 25.5GHz step 0.05GHz; Type=Discrete
source amplitudes:
  1:1, 1:2, 2:1, 2:2, 2:3, 3:1, 3:2, 4:1, 4:2: 0W 0deg
  1:3: -14dBm 0deg
optimetrics:
  OptimizationSetup1: Optimization Optimizer="DX AMO" AnalysisStopOptions{StopForNumIteration MaxNumIteration=110 MinNumIteration=10} CostFuncNormType=L2 Acceptable_Cost=0 Noise=0.0001 UpdateDesignWhenDone
    vary Ah1: Min=0mm Max=9.5mm MinStep=0.04mm MaxStep=0.4mm MinFocus=2mm MaxFocus=6mm start=4mm
    vary Ah2: Min=0mm Max=9.5mm MinStep=0.05mm MaxStep=0.5mm MinFocus=2.5mm MaxFocus=7.5mm start=5mm
    vary Ah3: Min=0mm Max=9.5mm MinStep=0.05mm MaxStep=0.5mm MinFocus=2.5mm MaxFocus=7.5mm start=5mm
    vary Ah4: Min=0mm Max=9.5mm MinStep=0.04mm MaxStep=0.4mm MinFocus=2mm MaxFocus=6mm start=4mm
    vary Ah5: Min=0mm Max=9.5mm MinStep=0.04mm MaxStep=0.4mm MinFocus=2mm MaxFocus=6mm start=4mm
    vary Al1: Min=0mm Max=9.5mm MinStep=0.04mm MaxStep=0.4mm MinFocus=2mm MaxFocus=6mm start=4mm
    vary Al2: Min=0mm Max=9.5mm MinStep=0.04mm MaxStep=0.4mm MinFocus=2mm MaxFocus=6mm start=4mm
    vary Al3: Min=0mm Max=9.5mm MinStep=0.04mm MaxStep=0.4mm MinFocus=2mm MaxFocus=6mm start=4mm
    vary Al4: Min=0mm Max=9.5mm MinStep=0.05mm MaxStep=0.5mm MinFocus=2.5mm MaxFocus=7.5mm start=5mm
    vary Al5: Min=0mm Max=9.5mm MinStep=0.05mm MaxStep=0.5mm MinFocus=2.5mm MaxFocus=7.5mm start=5mm
    vary Angle: Min=-60 Max=15 MinStep=0.3 MaxStep=3 MinFocus=-45 MaxFocus=-15 start=-30
    vary D1: Min=0mm Max=15mm MinStep=0.02mm MaxStep=0.2mm MinFocus=1mm MaxFocus=3mm start=2mm
    vary D2: Min=0mm Max=15mm MinStep=0.04mm MaxStep=0.4mm MinFocus=2mm MaxFocus=6mm start=4mm
    vary D3: Min=0mm Max=15mm MinStep=0.04mm MaxStep=0.4mm MinFocus=2mm MaxFocus=6mm start=4mm
    vary D4: Min=0mm Max=15mm MinStep=0.04mm MaxStep=0.4mm MinFocus=2mm MaxFocus=6mm start=4mm
    vary D5: Min=0mm Max=15mm MinStep=0.04mm MaxStep=0.4mm MinFocus=2mm MaxFocus=6mm start=4mm
    vary L1: Min=0mm Max=15mm MinStep=0.08mm MaxStep=0.8mm MinFocus=4mm MaxFocus=12mm start=8mm
    vary L2: Min=0mm Max=15mm MinStep=0.08mm MaxStep=0.8mm MinFocus=4mm MaxFocus=12mm start=8mm
    vary L3: Min=0mm Max=15mm MinStep=0.08mm MaxStep=0.8mm MinFocus=4mm MaxFocus=12mm start=8mm
    vary L4: Min=0mm Max=15mm MinStep=0.08mm MaxStep=0.8mm MinFocus=4mm MaxFocus=12mm start=8mm
    vary L5: Min=0mm Max=15mm MinStep=0.08mm MaxStep=0.8mm MinFocus=4mm MaxFocus=12mm start=8mm
    vary N: Min=1 Max=5 MinStep=0.04 MaxStep=0.4 MinFocus=2 MaxFocus=6 start=4
    vary chokeZshift: Min=0mm Max=20mm MinStep=0.15mm MaxStep=1.5mm MinFocus=7.5mm MaxFocus=22.5mm start=15mm
    vary cornerH: Min=0mm Max=30mm MinStep=0.14mm MaxStep=1.4mm MinFocus=7mm MaxFocus=21mm start=14mm
    vary cornerLen: Min=4mm Max=24mm MinStep=0.16mm MaxStep=1.6mm MinFocus=8mm MaxFocus=24mm start=16mm
    vary cornerLen1: Min=4mm Max=32mm MinStep=0.08mm MaxStep=0.8mm MinFocus=4mm MaxFocus=12mm start=30mm
    vary cornerWidth: Min=4mm Max=25mm MinStep=0.2mm MaxStep=2mm MinFocus=10mm MaxFocus=30mm start=20mm
    vary cornerWidth1: Min=4mm Max=25mm MinStep=0.1mm MaxStep=1mm MinFocus=5mm MaxFocus=15mm start=10mm
    vary rearPlasticLen: Min=15mm Max=35mm MinStep=0.15mm MaxStep=1.5mm MinFocus=7.5mm MaxFocus=22.5mm start=15mm
    vary trump0Len: Min=4mm Max=15mm MinStep=0.08mm MaxStep=0.8mm MinFocus=4mm MaxFocus=12mm start=8mm
    vary trump0Width: Min=4mm Max=15mm MinStep=0.1mm MaxStep=1mm MinFocus=5mm MaxFocus=15mm start=10mm
    vary trumpH: Min=10mm Max=45mm MinStep=0.4mm MaxStep=4mm MinFocus=20mm MaxFocus=60mm start=28mm
    goal dB(S(1:3,2:3)) >= -0.2 weight 1 on Auto1 : Sweep at Freq 22GHz to 26GHz
    goal dB(S(1:3,3)) >= -0.2 weight 1 on Auto1 : Sweep at Freq 22GHz to 26GHz
    goal dB(S(3,2:3)) >= -0.2 weight 1 on Auto1 : Sweep at Freq 22GHz to 26GHz
    goal dB(S(1:3,4:1)) <= -35 weight 1 on Auto1 : Sweep at Freq 22GHz to 26GHz
    goal dB(S(3:1,4:1)) <= -35 weight 1 on Auto1 : Sweep at Freq 22GHz to 26GHz
reports:
  S Parameter Plot 1: dB(S(1:3,2:3)), dB(S(1:3,3:1)), dB(S(3:1,2:3)), dB(S(1:3,4:1)), dB(S(3:1,4:1)) vs Freq on Auto1 : Sweep
  S Parameter Plot 2: dB(S(1:3,3:2)), dB(S(1:3,3:1)) vs Freq on Auto1 : Sweep
  Plot 1: dB(mag(S(1:3,3:1))+mag(S(1:3,3:2))) vs Freq on Auto1 : Sweep
  S Parameter Plot 3: dB(S(1:3,4:2)), dB(S(1:3,4:1)) vs Freq on Auto1 : Sweep
